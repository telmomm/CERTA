* Leapfrog low-pass, ITC'97 benchmark (Kondagunturi et al. 1999). See circuits.md.
* Op-amp: CMOS two-stage "Opamp2" of the benchmark, pins (-in +in out vdd vss).
.subckt opamp 4 5 8 1 11
.model mosn nmos vto=1 kp=17u gamma=1.3 lambda=0.01 phi=0.7
+ pb=0.8 mj=0.5 mjsw=.3 cgso=350p cgdo=350p cgbo=200p
+ cj=300u cjsw=500p ld=0.8u tox=80n
.model mosp pmos vto=-1 kp=8u gamma=.6 lambda=0.02 phi=0.6
+ pb=0.5 mj=0.5 mjsw=.25 cgso=350p cgdo=350p cgbo=200p
+ cj=150u cjsw=400p ld=0.8u tox=80n
m1 6 4 3 3 mosp w=20u l=10u
m2 7 5 3 3 mosp w=20u l=10u
m3 6 6 11 11 mosn w=36u l=10u
m4 7 6 11 11 mosn w=36u l=10u
m5 3 2a 1 1 mosp w=30u l=10u
m6 8 7 11 11 mosn w=100u l=10u
m7 8 2 1 1 mosp w=42u l=10u
m8 2 6 11 11 mosn w=60u l=10u
m9 2 2 1 1 mosp w=30u l=10u
cc 7 8 6p
vbias 2a 0 .1
.ends opamp
VIN 20 0 dc 0 ac 1
R1 20 2 10k
R2 2 4 10k
R3 10 2 10k
R4 4 5 10k
R5 5 7 10k
R6 7 8 10k
R7 10 11 10k
R8 13 14 10k
R9 14 16 10k
R10 17 19 10k
R11 16 17 10k
R12 19 11 10k
R13 13 5 10k
C1 2 4 10n
C2 8 10 20n
C3 11 13 20n
C4 17 19 10n
X1 2 0 4 vcc vee opamp
X2 5 0 7 vcc vee opamp
X3 8 0 10 vcc vee opamp
X4 11 0 13 vcc vee opamp
X5 14 0 16 vcc vee opamp
X6 17 0 19 vcc vee opamp
VDD vcc 0 dc 15
VSS vee 0 dc -15
.end
